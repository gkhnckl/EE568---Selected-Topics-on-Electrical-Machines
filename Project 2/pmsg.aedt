# Ansys Electronics Desktop project, version 2018.1
materials:
  M19-24G: permeability{BType=normal HUnit=A_per_meter BUnit=tesla curve (0, 0) (22.28, 0.05) (25.46, 0.1) (31.83, 0.15) (47.74, 0.36) (63.66, 0.54) (79.57, 0.65) (159.15, 0.99) (318.3, 1.2) (477.46, 1.28) (636.61, 1.33) (795.77, 1.36) (1591.5, 1.44) (3183, 1.52) (4774.6, 1.58) (6366.1, 1.63) (7957.7, 1.67) (15915, 1.8) (31830, 1.9) (111407, 2) (190984, 2.1) (350138, 2.3) (509292, 2.5)} core_loss_type="Electrical Steel" core_loss_kc=4.3255556 mass_density=7650
  XG196/96: permeability{BType=normal HUnit=A_per_meter BUnit=tesla curve (-690000, 0) (-663113.52, 0.048797862) (-635337.77, 0.097595724) (-606627.88, 0.14639359) (-576935.93, 0.19519145) (-546210.65, 0.24398931) (-514397.15, 0.29278717) (-481436.56, 0.34158503) (-447265.71, 0.39038289) (-411816.7, 0.43918076) (-375016.43, 0.48797862) (-333347.94, 0.54110533) (-291679.45, 0.5934675) (-250010.95, 0.64582967) (-208342.46, 0.69819184) (-166673.97, 0.75055402) (-125005.48, 0.80291619) (-83336.985, 0.85527836) (-41668.492, 0.90764053) (0, 0.96)}
  vacuum: permittivity=1
  M19-24G_2DSF0.950: permeability{BType=normal HUnit=A_per_meter BUnit=tesla curve (0, 0) (22.28, 0.0475014) (25.46, 0.0950016) (31.83, 0.142502) (47.74, 0.342003) (63.66, 0.513004) (79.57, 0.617505) (159.15, 0.94051) (318.3, 1.14002) (477.46, 1.21603) (636.61, 1.26354) (795.77, 1.29205) (1591.5, 1.3681) (3183, 1.4442) (4774.6, 1.5013) (6366.1, 1.5489) (7957.7, 1.587) (15915, 1.711) (31830, 1.807) (111407, 1.907) (190984, 2.007) (350138, 2.207) (509292, 2.407) (2100830, 4.407)} core_loss_type="Electrical Steel" core_loss_kc=4.55322 mass_density=7267.5
  XG196/96_2DSF1.000_N: CoordinateSystemType=Cylindrical permeability=1 magnetic_coercivity{Magnitude=-763939A_per_meter DirComp1=1 DirComp2=0 DirComp3=0}
  XG196/96_2DSF1.000_S: CoordinateSystemType=Cylindrical permeability=1 magnetic_coercivity{Magnitude=-763939A_per_meter DirComp1=-1 DirComp2=0 DirComp3=0}
  copper: permeability=0.999991 conductivity=58000000 mass_density=8933

design 20 pole 30 slot (RMxprt, Adjust-Speed Synchronous Machine, model units mm)
machine:
  Machine: FrictionLoss=12W WindLoss=0W ReferenceSpeed=1500rpm NumberOfPoles=20 RotorPosition=true ControlType=3 CircuitType=L3
  Stator: SkewWidth=0 NumberOfSlots=30 LaminationSectors=0 PressBoardThickness=0mm OuterDiameter=120mm InnerDiameter=75mm Length=65mm StackingFactor=0.95 SteelType=M19-24G SlotType=1
  Rotor: OuterDiameter=74mm InnerDiameter=26mm Length=65mm SteelType=M19-24G PoleType=1 StackingFactor=0.95
  Shaft:
  Stator Slot: Hs0=0.5mm Hs1=0mm Hs2=0mm Bs0=2.5mm Bs1=0mm Bs2=0mm Rs=0mm AutoDesign ToothWidth=0mm
  Stator Winding: WindingType=Whole-Coiled WindingLayers=2 ParallelBranches=2 ConductorsPerSlot=0 CoilPitch=1 EndAdjustment=0mm BaseInnerRadius=0mm TipInnerDiameter=0mm EndClearance=0mm CoilWrap=0mm SlotLiner=0.3mm WedgeThickness=0mm LayerInsulation=0mm BottomInsulation=0mm LimitedFillFactor=0.75 WdgNumberofPriodicMultipler=1 NumberOfStrands=2 WireWrap=0mm InterturnInsulation=0mm WireDiameter=0mm WireWidth=0mm WireThickness=0mm Gauge=AUTO
  Rotor Pole: Embrace=0.7 Offset=0mm ShaftDiameter=0mm Bridge=0mm Rib=0mm MagnetThickness=3.5mm MagnetWidth=0mm MagnetType=XG196/96
setups:
  Setup1: ASSM Generator RatedOutputPower=0.55kW RatedVoltage=127V RatedSpeed=1500rpm OperatingTemperature=75cel LoadType=InfiniteBus RatedPowerFactor=1
reports:
  Coil Voltage: OneConductorVoltage, OneTurnVoltage vs ElectricalDegree on Setup1 : Performance
  Current: LineCurrentAC, LineCurrentBA, LineCurrentCB, PhaseCurrent1a, PhaseCurrent1b, PhaseCurrent1c, PhaseCurrent1d, SourceCurrent vs ElectricalDegree on Setup1 : Performance
  Flux Density: AirGapFluxDensity vs ElectricalDegree on Setup1 : Performance
  Induced Voltage: InducedLineVoltage, InducedPhaseVoltage vs ElectricalDegree on Setup1 : Performance
  Torque: CoggingTorque vs ElectricalDegree on Setup1 : Performance
  Voltage: LineVoltage, PhaseVoltage vs ElectricalDegree on Setup1 : Performance
  Current1: InputCurrent vs Ang on Setup1 : Performance
  Misc.: AirGapTorqueToDCCurrentRatio vs Ang on Setup1 : Performance
  Percentage: Efficiency vs Ang on Setup1 : Performance
  Power: AirGapPower vs Ang on Setup1 : Performance

design 20 pole 24 slot (RMxprt, Adjust-Speed Synchronous Machine, model units mm)
options: UDDEnabled UDD("Fractions 1")
machine:
  Machine: FrictionLoss=12W WindLoss=0W ReferenceSpeed=1500rpm NumberOfPoles=20 RotorPosition=true ControlType=3 CircuitType=L3
  Stator: SkewWidth=0 NumberOfSlots=24 LaminationSectors=0 PressBoardThickness=0mm OuterDiameter=120mm InnerDiameter=75mm Length=65mm StackingFactor=0.95 SteelType=M19-24G SlotType=1
  Rotor: OuterDiameter=74mm InnerDiameter=26mm Length=65mm SteelType=M19-24G PoleType=1 StackingFactor=0.95
  Shaft:
  Stator Slot: Hs0=0.5mm Hs1=0mm Hs2=0mm Bs0=2.5mm Bs1=0mm Bs2=0mm Rs=0mm AutoDesign ToothWidth=0mm
  Stator Winding: WindingType=Whole-Coiled WindingLayers=2 ParallelBranches=2 ConductorsPerSlot=0 CoilPitch=1 EndAdjustment=0mm BaseInnerRadius=0mm TipInnerDiameter=0mm EndClearance=0mm CoilWrap=0mm SlotLiner=0.3mm WedgeThickness=0mm LayerInsulation=0mm BottomInsulation=0mm LimitedFillFactor=0.75 WdgNumberofPriodicMultipler=1 NumberOfStrands=2 WireWrap=0mm InterturnInsulation=0mm WireDiameter=0mm WireWidth=0mm WireThickness=0mm Gauge=AUTO
  Rotor Pole: Embrace=0.7 Offset=0mm ShaftDiameter=0mm Bridge=0mm Rib=0mm MagnetThickness=3.5mm MagnetWidth=0mm MagnetType=XG196/96
setups:
  Setup1: ASSM Generator RatedOutputPower=0.55kW RatedVoltage=127V RatedSpeed=1500rpm OperatingTemperature=75cel LoadType=InfiniteBus RatedPowerFactor=1

design Maxwell2DDesign1 (Maxwell 2D, Transient, XY geometry, model units mm)
options: ModelDepth=65mm Multiplier=fractions
variables:
  fractions = 1
geometry:
  Band [vacuum] = user_primitive(RMxprt/Band, DiaGap=74.5mm, DiaYoke=26mm, Length=0mm, SegAngle=0deg, Fractions=1, HalfAxial=0, InfoCore=0)
  Shaft [vacuum] = user_primitive(RMxprt/Band, DiaGap=74.5mm, DiaYoke=26mm, Length=0mm, SegAngle=0deg, Fractions=1, HalfAxial=0, InfoCore=100)
  OuterRegion [vacuum] = user_primitive(RMxprt/Band, DiaGap=74.5mm, DiaYoke=120mm, Length=0mm, SegAngle=0deg, Fractions=fractions, HalfAxial=0, InfoCore=100)
  Tool = user_primitive(RMxprt/Band, DiaGap=74.5mm, DiaYoke=120mm, Length=0mm, SegAngle=0deg, Fractions=fractions, HalfAxial=0, InfoCore=1)
  Stator [M19-24G_2DSF0.950] = user_primitive(RMxprt/SlotCore, DiaGap=75mm, DiaYoke=120mm, Length=0mm, Skew=0deg, Slots=24, SlotType=1, Hs0=0.5mm, Hs01=0mm, Hs1=0mm, Hs2=10.082916mm, Bs0=2.5mm, Bs1=5.6500582mm, Bs2=8.3049403mm, Rs=4.1524701mm, FilletType=0, HalfSlot=0, SegAngle=15deg, LenRegion=0mm, InfoCore=0)
  Coil_0 [copper] = user_primitive(RMxprt/LapCoil, DiaGap=75mm, DiaYoke=120mm, Length=0mm, Skew=0deg, Slots=24, SlotType=1, Hs0=0.5mm, Hs1=0mm, Hs2=10.082916mm, Bs0=2.5mm, Bs1=5.6500582mm, Bs2=8.3049403mm, Rs=4.1524701mm, FilletType=0, Layers=2, CoilPitch=1, EndExt=0mm, SpanExt=0mm, BendAngle=0deg, SegAngle=10deg, LenRegion=0mm, InfoCoil=2)
  Coil_1..Coil_23 [copper] = Coil_0.duplicate_around_axis(axis=Z, angle=15deg, total=24)
  CoilRe_0 [copper] = user_primitive(RMxprt/LapCoil, DiaGap=75mm, DiaYoke=120mm, Length=0mm, Skew=0deg, Slots=24, SlotType=1, Hs0=0.5mm, Hs1=0mm, Hs2=10.082916mm, Bs0=2.5mm, Bs1=5.6500582mm, Bs2=8.3049403mm, Rs=4.1524701mm, FilletType=0, Layers=2, CoilPitch=1, EndExt=0mm, SpanExt=0mm, BendAngle=0deg, SegAngle=10deg, LenRegion=0mm, InfoCoil=3)
  CoilRe_0.rotate(axis=Z, angle=-15deg)
  CoilRe_1..CoilRe_23 [copper] = CoilRe_0.duplicate_around_axis(axis=Z, angle=15deg, total=24)
  Rotor [M19-24G_2DSF0.950] = user_primitive(RMxprt/PMCore, DiaGap=74mm, DiaYoke=26mm, Length=0mm, Poles=20, PoleType=1, Embrace=0.7, ThickMag=3.5mm, WidthMag=0mm, Offset=0mm, Bridge=0mm, Rib=0mm, LenRegion=0mm, InfoCore=0)
  Mag_0 [XG196/96_2DSF1.000_N] = user_primitive(RMxprt/PMCore, DiaGap=74mm, DiaYoke=26mm, Length=0mm, Poles=20, PoleType=1, Embrace=0.7, ThickMag=3.5mm, WidthMag=0mm, Offset=0mm, Bridge=0mm, Rib=0mm, LenRegion=0mm, InfoCore=2)
  Mag_1 [XG196/96_2DSF1.000_S], Mag_2 [XG196/96_2DSF1.000_N], Mag_3 [XG196/96_2DSF1.000_S], Mag_4 [XG196/96_2DSF1.000_N], Mag_5 [XG196/96_2DSF1.000_S], Mag_6 [XG196/96_2DSF1.000_N], Mag_7 [XG196/96_2DSF1.000_S], Mag_8 [XG196/96_2DSF1.000_N], Mag_9 [XG196/96_2DSF1.000_S], Mag_10 [XG196/96_2DSF1.000_N], Mag_11 [XG196/96_2DSF1.000_S], Mag_12 [XG196/96_2DSF1.000_N], Mag_13 [XG196/96_2DSF1.000_S], Mag_14 [XG196/96_2DSF1.000_N], Mag_15 [XG196/96_2DSF1.000_S], Mag_16 [XG196/96_2DSF1.000_N], Mag_17 [XG196/96_2DSF1.000_S], Mag_18 [XG196/96_2DSF1.000_N], Mag_19 [XG196/96_2DSF1.000_S] = Mag_0.duplicate_around_axis(axis=Z, angle=18deg, total=20)
  InnerRegion [vacuum] = user_primitive(RMxprt/PMCore, DiaGap=74mm, DiaYoke=26mm, Length=0mm, Poles=20, PoleType=1, Embrace=0.7, ThickMag=3.5mm, WidthMag=0mm, Offset=0mm, Bridge=0mm, Rib=0mm, LenRegion=0mm, InfoCore=100)
  Tool_1 = Tool.copy()
  Band.subtract(Tool_1)
  Tool_2 = Tool.copy()
  InnerRegion.subtract(Tool_2)
  Tool_3 = Tool.copy()
  Shaft.subtract(Tool_3)
  Tool_4 = Tool.copy()
  Stator.subtract(Tool_4)
  Tool_5 = Tool.copy()
  Coil_0.subtract(Tool_5)
  Tool_6 = Tool.copy()
  Coil_1.subtract(Tool_6)
  Tool_7 = Tool.copy()
  Coil_2.subtract(Tool_7)
  Tool_8 = Tool.copy()
  Coil_3.subtract(Tool_8)
  Tool_9 = Tool.copy()
  Coil_4.subtract(Tool_9)
  Tool_10 = Tool.copy()
  Coil_5.subtract(Tool_10)
  Tool_11 = Tool.copy()
  Coil_6.subtract(Tool_11)
  Tool_12 = Tool.copy()
  Coil_7.subtract(Tool_12)
  Tool_13 = Tool.copy()
  Coil_8.subtract(Tool_13)
  Tool_14 = Tool.copy()
  Coil_9.subtract(Tool_14)
  Tool_15 = Tool.copy()
  Coil_10.subtract(Tool_15)
  Tool_16 = Tool.copy()
  Coil_11.subtract(Tool_16)
  Tool_17 = Tool.copy()
  Coil_12.subtract(Tool_17)
  Tool_18 = Tool.copy()
  Coil_13.subtract(Tool_18)
  Tool_19 = Tool.copy()
  Coil_14.subtract(Tool_19)
  Tool_20 = Tool.copy()
  Coil_15.subtract(Tool_20)
  Tool_21 = Tool.copy()
  Coil_16.subtract(Tool_21)
  Tool_22 = Tool.copy()
  Coil_17.subtract(Tool_22)
  Tool_23 = Tool.copy()
  Coil_18.subtract(Tool_23)
  Tool_24 = Tool.copy()
  Coil_19.subtract(Tool_24)
  Tool_25 = Tool.copy()
  Coil_20.subtract(Tool_25)
  Tool_26 = Tool.copy()
  Coil_21.subtract(Tool_26)
  Tool_27 = Tool.copy()
  Coil_22.subtract(Tool_27)
  Tool_28 = Tool.copy()
  Coil_23.subtract(Tool_28)
  Tool_29 = Tool.copy()
  CoilRe_0.subtract(Tool_29)
  Tool_30 = Tool.copy()
  CoilRe_1.subtract(Tool_30)
  Tool_31 = Tool.copy()
  CoilRe_2.subtract(Tool_31)
  Tool_32 = Tool.copy()
  CoilRe_3.subtract(Tool_32)
  Tool_33 = Tool.copy()
  CoilRe_4.subtract(Tool_33)
  Tool_34 = Tool.copy()
  CoilRe_5.subtract(Tool_34)
  Tool_35 = Tool.copy()
  CoilRe_6.subtract(Tool_35)
  Tool_36 = Tool.copy()
  CoilRe_7.subtract(Tool_36)
  Tool_37 = Tool.copy()
  CoilRe_8.subtract(Tool_37)
  Tool_38 = Tool.copy()
  CoilRe_9.subtract(Tool_38)
  Tool_39 = Tool.copy()
  CoilRe_10.subtract(Tool_39)
  Tool_40 = Tool.copy()
  CoilRe_11.subtract(Tool_40)
  Tool_41 = Tool.copy()
  CoilRe_12.subtract(Tool_41)
  Tool_42 = Tool.copy()
  CoilRe_13.subtract(Tool_42)
  Tool_43 = Tool.copy()
  CoilRe_14.subtract(Tool_43)
  Tool_44 = Tool.copy()
  CoilRe_15.subtract(Tool_44)
  Tool_45 = Tool.copy()
  CoilRe_16.subtract(Tool_45)
  Tool_46 = Tool.copy()
  CoilRe_17.subtract(Tool_46)
  Tool_47 = Tool.copy()
  CoilRe_18.subtract(Tool_47)
  Tool_48 = Tool.copy()
  CoilRe_19.subtract(Tool_48)
  Tool_49 = Tool.copy()
  CoilRe_20.subtract(Tool_49)
  Tool_50 = Tool.copy()
  CoilRe_21.subtract(Tool_50)
  Tool_51 = Tool.copy()
  CoilRe_22.subtract(Tool_51)
  Tool_52 = Tool.copy()
  CoilRe_23.subtract(Tool_52)
  Tool_53 = Tool.copy()
  Rotor.subtract(Tool_53)
  Tool_54 = Tool.copy()
  Mag_0.subtract(Tool_54)
  Tool_55 = Tool.copy()
  Mag_1.subtract(Tool_55)
  Tool_56 = Tool.copy()
  Mag_2.subtract(Tool_56)
  Tool_57 = Tool.copy()
  Mag_3.subtract(Tool_57)
  Tool_58 = Tool.copy()
  Mag_4.subtract(Tool_58)
  Tool_59 = Tool.copy()
  Mag_5.subtract(Tool_59)
  Tool_60 = Tool.copy()
  Mag_6.subtract(Tool_60)
  Tool_61 = Tool.copy()
  Mag_7.subtract(Tool_61)
  Tool_62 = Tool.copy()
  Mag_8.subtract(Tool_62)
  Tool_63 = Tool.copy()
  Mag_9.subtract(Tool_63)
  Tool_64 = Tool.copy()
  Mag_10.subtract(Tool_64)
  Tool_65 = Tool.copy()
  Mag_11.subtract(Tool_65)
  Tool_66 = Tool.copy()
  Mag_12.subtract(Tool_66)
  Tool_67 = Tool.copy()
  Mag_13.subtract(Tool_67)
  Tool_68 = Tool.copy()
  Mag_14.subtract(Tool_68)
  Tool_69 = Tool.copy()
  Mag_15.subtract(Tool_69)
  Tool_70 = Tool.copy()
  Mag_16.subtract(Tool_70)
  Tool_71 = Tool.copy()
  Mag_17.subtract(Tool_71)
  Tool_72 = Tool.copy()
  Mag_18.subtract(Tool_72)
  Mag_19.subtract(Tool)
motion:
  MotionSetup1: Band Move_Type=Rotate Coordinate_System=Global Axis=Z Is_Positive=true InitPos=7.5deg Angular_Velocity=1500rpm Objects=Band
  Moving1: Moving Objects=[Shaft, Rotor, Mag_0..Mag_19, InnerRegion]
boundaries and excitations:
  VectorPotential1: Vector Potential Edges=OuterRegion.edge(at (0, 60, 0)) Value=0
  PhA_0: Coil Objects=Coil_0 Conductor_number=80 Winding=PhaseA PolarityType=Positive
  PhARe_0: Coil Objects=CoilRe_1 Conductor_number=80 Winding=PhaseA PolarityType=Negative
  PhB_1: Coil Objects=Coil_1 Conductor_number=80 Winding=PhaseB PolarityType=Positive
  PhBRe_1: Coil Objects=CoilRe_2 Conductor_number=80 Winding=PhaseB PolarityType=Negative
  PhBRe_2: Coil Objects=Coil_2 Conductor_number=80 Winding=PhaseB PolarityType=Negative
  PhB_2: Coil Objects=CoilRe_3 Conductor_number=80 Winding=PhaseB PolarityType=Positive
  PhCRe_3: Coil Objects=Coil_3 Conductor_number=80 Winding=PhaseC PolarityType=Negative
  PhC_3: Coil Objects=CoilRe_4 Conductor_number=80 Winding=PhaseC PolarityType=Positive
  PhC_4: Coil Objects=Coil_4 Conductor_number=80 Winding=PhaseC PolarityType=Positive
  PhCRe_4: Coil Objects=CoilRe_5 Conductor_number=80 Winding=PhaseC PolarityType=Negative
  PhA_5: Coil Objects=Coil_5 Conductor_number=80 Winding=PhaseA PolarityType=Positive
  PhARe_5: Coil Objects=CoilRe_6 Conductor_number=80 Winding=PhaseA PolarityType=Negative
  PhARe_6: Coil Objects=Coil_6 Conductor_number=80 Winding=PhaseA PolarityType=Negative
  PhA_6: Coil Objects=CoilRe_7 Conductor_number=80 Winding=PhaseA PolarityType=Positive
  PhBRe_7: Coil Objects=Coil_7 Conductor_number=80 Winding=PhaseB PolarityType=Negative
  PhB_7: Coil Objects=CoilRe_8 Conductor_number=80 Winding=PhaseB PolarityType=Positive
  PhB_8: Coil Objects=Coil_8 Conductor_number=80 Winding=PhaseB PolarityType=Positive
  PhBRe_8: Coil Objects=CoilRe_9 Conductor_number=80 Winding=PhaseB PolarityType=Negative
  PhC_9: Coil Objects=Coil_9 Conductor_number=80 Winding=PhaseC PolarityType=Positive
  PhCRe_9: Coil Objects=CoilRe_10 Conductor_number=80 Winding=PhaseC PolarityType=Negative
  PhCRe_10: Coil Objects=Coil_10 Conductor_number=80 Winding=PhaseC PolarityType=Negative
  PhC_10: Coil Objects=CoilRe_11 Conductor_number=80 Winding=PhaseC PolarityType=Positive
  PhARe_11: Coil Objects=Coil_11 Conductor_number=80 Winding=PhaseA PolarityType=Negative
  PhA_11: Coil Objects=CoilRe_12 Conductor_number=80 Winding=PhaseA PolarityType=Positive
  PhA_12: Coil Objects=Coil_12 Conductor_number=80 Winding=PhaseA PolarityType=Positive
  PhARe_12: Coil Objects=CoilRe_13 Conductor_number=80 Winding=PhaseA PolarityType=Negative
  PhB_13: Coil Objects=Coil_13 Conductor_number=80 Winding=PhaseB PolarityType=Positive
  PhBRe_13: Coil Objects=CoilRe_14 Conductor_number=80 Winding=PhaseB PolarityType=Negative
  PhBRe_14: Coil Objects=Coil_14 Conductor_number=80 Winding=PhaseB PolarityType=Negative
  PhB_14: Coil Objects=CoilRe_15 Conductor_number=80 Winding=PhaseB PolarityType=Positive
  PhCRe_15: Coil Objects=Coil_15 Conductor_number=80 Winding=PhaseC PolarityType=Negative
  PhC_15: Coil Objects=CoilRe_16 Conductor_number=80 Winding=PhaseC PolarityType=Positive
  PhC_16: Coil Objects=Coil_16 Conductor_number=80 Winding=PhaseC PolarityType=Positive
  PhCRe_16: Coil Objects=CoilRe_17 Conductor_number=80 Winding=PhaseC PolarityType=Negative
  PhA_17: Coil Objects=Coil_17 Conductor_number=80 Winding=PhaseA PolarityType=Positive
  PhARe_17: Coil Objects=CoilRe_18 Conductor_number=80 Winding=PhaseA PolarityType=Negative
  PhARe_18: Coil Objects=Coil_18 Conductor_number=80 Winding=PhaseA PolarityType=Negative
  PhA_18: Coil Objects=CoilRe_19 Conductor_number=80 Winding=PhaseA PolarityType=Positive
  PhBRe_19: Coil Objects=Coil_19 Conductor_number=80 Winding=PhaseB PolarityType=Negative
  PhB_19: Coil Objects=CoilRe_20 Conductor_number=80 Winding=PhaseB PolarityType=Positive
  PhB_20: Coil Objects=Coil_20 Conductor_number=80 Winding=PhaseB PolarityType=Positive
  PhBRe_20: Coil Objects=CoilRe_21 Conductor_number=80 Winding=PhaseB PolarityType=Negative
  PhC_21: Coil Objects=Coil_21 Conductor_number=80 Winding=PhaseC PolarityType=Positive
  PhCRe_21: Coil Objects=CoilRe_22 Conductor_number=80 Winding=PhaseC PolarityType=Negative
  PhCRe_22: Coil Objects=Coil_22 Conductor_number=80 Winding=PhaseC PolarityType=Negative
  PhC_22: Coil Objects=CoilRe_23 Conductor_number=80 Winding=PhaseC PolarityType=Positive
  PhARe_23: Coil Objects=Coil_23 Conductor_number=80 Winding=PhaseA PolarityType=Negative
  PhA_23: Coil Objects=CoilRe_0 Conductor_number=80 Winding=PhaseA PolarityType=Positive
  PhaseA: Winding Group Type=Voltage IsSolid=false Current=0A Resistance=2.00317ohm Inductance=3.69397e-05H Voltage="179.605 * sin(2*pi*250*time-8.17689*pi/180)" ParallelBranchesNum=2
  PhaseB: Winding Group Type=Voltage IsSolid=false Current=0A Resistance=2.00317ohm Inductance=3.69397e-05H Voltage="179.605 * sin(2*pi*250*time-8.17689*pi/180-2*pi/3)" ParallelBranchesNum=2
  PhaseC: Winding Group Type=Voltage IsSolid=false Current=0A Resistance=2.00317ohm Inductance=3.69397e-05H Voltage="179.605 * sin(2*pi*250*time-8.17689*pi/180-4*pi/3)" ParallelBranchesNum=2
mesh:
  SurfApprox_Mag: SurfApproxBased Objects=[Mag_0..Mag_19] CurvedSurfaceApproxChoice=ManualSettings SurfDev=0.037mm NormalDev=15deg
  SurfApprox_Main: SurfApproxBased Objects=[Stator, Rotor, Band, OuterRegion, InnerRegion, Shaft] CurvedSurfaceApproxChoice=ManualSettings SurfDev=0.06mm NormalDev=15deg
  initial mesh: MeshMethod=AnsoftTAU
setups:
  Setup1: Transient NonlinearSolverResidual=0.0001 SmoothBHCurve StopTime=0.04s TimeStep=4e-05s FastReachSteadyState AutoDetectSteadyState FrequencyOfAddedVoltageSource=250Hz StopCriterion=0.005 InitialTimeStep=0.002s MinTimeStep=0.001s MaxTimeStep=0.003s TimeStepErrTolerance=0.0001
reports:
  Torque: Moving1.Torque vs Time on Setup1 : Transient
  Currents: Current(PhaseA), Current(PhaseB), Current(PhaseC) vs Time on Setup1 : Transient
  Induced Voltages: InducedVoltage(PhaseA), InducedVoltage(PhaseB), InducedVoltage(PhaseC) vs Time on Setup1 : Transient
  Flux Linkages: FluxLinkage(PhaseA), FluxLinkage(PhaseB), FluxLinkage(PhaseC) vs Time on Setup1 : Transient
  Voltages: InputVoltage(PhaseA), InputVoltage(PhaseB), InputVoltage(PhaseC) vs Time on Setup1 : Transient
  Powers: InputVoltage(PhaseA)*Current(PhaseA) + InputVoltage(PhaseB)*Current(PhaseB) + InputVoltage(PhaseC)*Current(PhaseC), Moving1.Speed*Moving1.Torque vs Time on Setup1 : Transient
