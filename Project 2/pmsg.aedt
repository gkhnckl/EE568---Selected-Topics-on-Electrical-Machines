# Ansys Electronics Desktop project, version 2018.1
materials:
  M19-24G: permeability{BType=normal HUnit=A_per_meter BUnit=tesla curve (0, 0) (22.28, 0.05) (25.46, 0.1) (31.83, 0.15) (47.74, 0.36) (63.66, 0.54) (79.57, 0.65) (159.15, 0.99) (318.3, 1.2) (477.46, 1.28) (636.61, 1.33) (795.77, 1.36) (1591.5, 1.44) (3183, 1.52) (4774.6, 1.58) (6366.1, 1.63) (7957.7, 1.67) (15915, 1.8) (31830, 1.9) (111407, 2) (190984, 2.1) (350138, 2.3) (509292, 2.5)} core_loss_type="Electrical Steel" core_loss_kc=4.3255556 mass_density=7650
  XG196/96: permeability{BType=normal HUnit=A_per_meter BUnit=tesla curve (-690000, 0) (-663113.52, 0.048797862) (-635337.77, 0.097595724) (-606627.88, 0.14639359) (-576935.93, 0.19519145) (-546210.65, 0.24398931) (-514397.15, 0.29278717) (-481436.56, 0.34158503) (-447265.71, 0.39038289) (-411816.7, 0.43918076) (-375016.43, 0.48797862) (-333347.94, 0.54110533) (-291679.45, 0.5934675) (-250010.95, 0.64582967) (-208342.46, 0.69819184) (-166673.97, 0.75055402) (-125005.48, 0.80291619) (-83336.985, 0.85527836) (-41668.492, 0.90764053) (0, 0.96)}

design 20 pole 30 slot (RMxprt, Adjust-Speed Synchronous Machine, model units mm)
machine:
  Machine: FrictionLoss=12W WindLoss=0W ReferenceSpeed=1500rpm NumberOfPoles=20 RotorPosition=true ControlType=3 CircuitType=L3
  Stator: SkewWidth=0 NumberOfSlots=30 LaminationSectors=0 PressBoardThickness=0mm OuterDiameter=120mm InnerDiameter=75mm Length=65mm StackingFactor=0.95 SteelType=M19-24G SlotType=1
  Rotor: OuterDiameter=74mm InnerDiameter=26mm Length=65mm SteelType=M19-24G PoleType=1 StackingFactor=0.95
  Shaft:
  Stator Slot: Hs0=0.5mm Hs1=0mm Hs2=0mm Bs0=2.5mm Bs1=0mm Bs2=0mm Rs=0mm AutoDesign ToothWidth=0mm
  Stator Winding: WindingType=Whole-Coiled WindingLayers=2 ParallelBranches=2 ConductorsPerSlot=0 CoilPitch=5 EndAdjustment=0mm BaseInnerRadius=0mm TipInnerDiameter=0mm EndClearance=0mm CoilWrap=0mm SlotLiner=0.3mm WedgeThickness=0mm LayerInsulation=0mm BottomInsulation=0mm LimitedFillFactor=0.75 WdgNumberofPriodicMultipler=1 NumberOfStrands=2 WireWrap=0mm InterturnInsulation=0mm WireDiameter=0mm WireWidth=0mm WireThickness=0mm Gauge=AUTO
  Rotor Pole: Embrace=0.7 Offset=0mm ShaftDiameter=0mm Bridge=0mm Rib=0mm MagnetThickness=3.5mm MagnetWidth=0mm MagnetType=XG196/96
setups:
  Setup1: ASSM Generator RatedOutputPower=0.55kW RatedVoltage=127V RatedSpeed=1500rpm OperatingTemperature=75cel LoadType=InfiniteBus RatedPowerFactor=1

design 20 pole 24 slot (RMxprt, Adjust-Speed Synchronous Machine, model units mm)
machine:
  Machine: FrictionLoss=12W WindLoss=0W ReferenceSpeed=1500rpm NumberOfPoles=20 RotorPosition=true ControlType=3 CircuitType=L3
  Stator: SkewWidth=0 NumberOfSlots=24 LaminationSectors=0 PressBoardThickness=0mm OuterDiameter=120mm InnerDiameter=75mm Length=65mm StackingFactor=0.95 SteelType=M19-24G SlotType=1
  Rotor: OuterDiameter=74mm InnerDiameter=26mm Length=65mm SteelType=M19-24G PoleType=1 StackingFactor=0.95
  Shaft:
  Stator Slot: Hs0=0.5mm Hs1=0mm Hs2=0mm Bs0=2.5mm Bs1=0mm Bs2=0mm Rs=0mm AutoDesign ToothWidth=0mm
  Stator Winding: WindingType=Whole-Coiled WindingLayers=2 ParallelBranches=2 ConductorsPerSlot=0 CoilPitch=5 EndAdjustment=0mm BaseInnerRadius=0mm TipInnerDiameter=0mm EndClearance=0mm CoilWrap=0mm SlotLiner=0.3mm WedgeThickness=0mm LayerInsulation=0mm BottomInsulation=0mm LimitedFillFactor=0.75 WdgNumberofPriodicMultipler=1 NumberOfStrands=2 WireWrap=0mm InterturnInsulation=0mm WireDiameter=0mm WireWidth=0mm WireThickness=0mm Gauge=AUTO
  Rotor Pole: Embrace=0.7 Offset=0mm ShaftDiameter=0mm Bridge=0mm Rib=0mm MagnetThickness=3.5mm MagnetWidth=0mm MagnetType=XG196/96
setups:
  Setup1: ASSM Generator RatedOutputPower=0.55kW RatedVoltage=127V RatedSpeed=1500rpm OperatingTemperature=75cel LoadType=InfiniteBus RatedPowerFactor=1
