# Ansys Electronics Desktop project, version 2018.1
materials:
  M19-24G: permeability{BType=normal HUnit=A_per_meter BUnit=tesla curve (0, 0) (22.28, 0.05) (25.46, 0.1) (31.83, 0.15) (47.74, 0.36) (63.66, 0.54) (79.57, 0.65) (159.15, 0.99) (318.3, 1.2) (477.46, 1.28) (636.61, 1.33) (795.77, 1.36) (1591.5, 1.44) (3183, 1.52) (4774.6, 1.58) (6366.1, 1.63) (7957.7, 1.67) (15915, 1.8) (31830, 1.9) (111407, 2) (190984, 2.1) (350138, 2.3) (509292, 2.5)} core_loss_type="Electrical Steel" core_loss_kc=4.3255556 mass_density=7650
  XG196/96: permeability{BType=normal HUnit=A_per_meter BUnit=tesla curve (-690000, 0) (-663113.52, 0.048797862) (-635337.77, 0.097595724) (-606627.88, 0.14639359) (-576935.93, 0.19519145) (-546210.65, 0.24398931) (-514397.15, 0.29278717) (-481436.56, 0.34158503) (-447265.71, 0.39038289) (-411816.7, 0.43918076) (-375016.43, 0.48797862) (-333347.94, 0.54110533) (-291679.45, 0.5934675) (-250010.95, 0.64582967) (-208342.46, 0.69819184) (-166673.97, 0.75055402) (-125005.48, 0.80291619) (-83336.985, 0.85527836) (-41668.492, 0.90764053) (0, 0.96)}
  vacuum: permittivity=1
  M19-24G_2DSF0.950: permeability{BType=normal HUnit=A_per_meter BUnit=tesla curve (0, 0) (22.28, 0.0475014) (25.46, 0.0950016) (31.83, 0.142502) (47.74, 0.342003) (63.66, 0.513004) (79.57, 0.617505) (159.15, 0.94051) (318.3, 1.14002) (477.46, 1.21603) (636.61, 1.26354) (795.77, 1.29205) (1591.5, 1.3681) (3183, 1.4442) (4774.6, 1.5013) (6366.1, 1.5489) (7957.7, 1.587) (15915, 1.711) (31830, 1.807) (111407, 1.907) (190984, 2.007) (350138, 2.207) (509292, 2.407) (2100830, 4.407)} core_loss_type="Electrical Steel" core_loss_kc=4.55322 mass_density=7267.5
  XG196/96_2DSF1.000_N: CoordinateSystemType=Cylindrical permeability=1 magnetic_coercivity{Magnitude=-763939A_per_meter DirComp1=1 DirComp2=0 DirComp3=0}
  XG196/96_2DSF1.000_S: CoordinateSystemType=Cylindrical permeability=1 magnetic_coercivity{Magnitude=-763939A_per_meter DirComp1=-1 DirComp2=0 DirComp3=0}
  copper: permeability=0.999991 conductivity=58000000 mass_density=8933
  NdFe42: permittivity=1 permeability=1.05 conductivity=625000 magnetic_coercivity{Magnitude=-996613.1A_per_meter DirComp1=1 DirComp2=0 DirComp3=0} lande_g_factor=2 mass_density=7400
  NdFe42_2DSF1.000_N: CoordinateSystemType=Cylindrical permeability=1.05 conductivity=625000 magnetic_coercivity{Magnitude=-996613A_per_meter DirComp1=1 DirComp2=0 DirComp3=0} mass_density=7400
  NdFe42_2DSF1.000_S: CoordinateSystemType=Cylindrical permeability=1.05 conductivity=625000 magnetic_coercivity{Magnitude=-996613A_per_meter DirComp1=-1 DirComp2=0 DirComp3=0} mass_density=7400
  M19-24G_2DSF0.951: permeability=50000000 core_loss_type="Electrical Steel" core_loss_kc=4.55322 mass_density=7267.5

design transient (Maxwell 2D, Transient, XY geometry, model units mm)
options: ModelDepth=100mm Multiplier=fractions
variables:
  fractions = 1
geometry:
  Band [vacuum] = user_primitive(RMxprt/Band, DiaGap=67.3mm, DiaYoke=34mm, Length=0mm, SegAngle=0deg, Fractions=1, HalfAxial=0, InfoCore=0)
  Shaft [vacuum] = user_primitive(RMxprt/Band, DiaGap=101mm, DiaYoke=34mm, Length=0mm, SegAngle=0deg, Fractions=1, HalfAxial=0, InfoCore=100)
  OuterRegion [vacuum] = user_primitive(RMxprt/Band, DiaGap=101mm, DiaYoke=160mm, Length=0mm, SegAngle=0deg, Fractions=fractions, HalfAxial=0, InfoCore=100)
  Tool = user_primitive(RMxprt/Band, DiaGap=101mm, DiaYoke=160mm, Length=0mm, SegAngle=0deg, Fractions=fractions, HalfAxial=0, InfoCore=1)
  Stator [M19-24G_2DSF0.950] = user_primitive(RMxprt/SlotCore, DiaGap=68.3mm, DiaYoke=160mm, Length=0mm, Skew=0deg, Slots=24, SlotType=3, Hs0=0.0001mm, Hs01=0mm, Hs1=1.1526093mm, Hs2=24.72mm, Bs0=6.65mm, Bs1=6.9927559mm, Bs2=10.107162mm, Rs=0mm, FilletType=0, HalfSlot=0, SegAngle=15deg, LenRegion=0mm, InfoCore=0)
  Coil_0 [copper] = user_primitive(RMxprt/LapCoil, DiaGap=68.3mm, DiaYoke=160mm, Length=0mm, Skew=0deg, Slots=24, SlotType=3, Hs0=0.0001mm, Hs1=1.1526093mm, Hs2=21.86mm, Bs0=3mm, Bs1=6.9927559mm, Bs2=10.107162mm, Rs=0mm, FilletType=0, Layers=1, CoilPitch=5, EndExt=0mm, SpanExt=0mm, BendAngle=0deg, SegAngle=10deg, LenRegion=0mm, InfoCoil=2)
  Coil_1..Coil_23 [copper] = Coil_0.duplicate_around_axis(axis=Z, angle=15deg, total=24)
  Rotor [M19-24G_2DSF0.950] = user_primitive(RMxprt/PMCore, DiaGap=66.3mm, DiaYoke=34mm, Length=0mm, Poles=4, PoleType=1, Embrace=0.8, ThickMag=4mm, WidthMag=0mm, Offset=0mm, Bridge=0mm, Rib=0mm, LenRegion=0mm, InfoCore=0)
  Mag_0 [NdFe42_2DSF1.000_N] = user_primitive(RMxprt/PMCore, DiaGap=66.3mm, DiaYoke=34mm, Length=0mm, Poles=4, PoleType=1, Embrace=0.8, ThickMag=4mm, WidthMag=0mm, Offset=0mm, Bridge=0mm, Rib=0mm, LenRegion=0mm, InfoCore=2)
  Mag_1 [NdFe42_2DSF1.000_S], Mag_2 [NdFe42_2DSF1.000_N], Mag_3 [NdFe42_2DSF1.000_S] = Mag_0.duplicate_around_axis(axis=Z, angle=90deg, total=4)
  InnerRegion [vacuum] = user_primitive(RMxprt/PMCore, DiaGap=66.3mm, DiaYoke=34mm, Length=0mm, Poles=4, PoleType=1, Embrace=0.8, ThickMag=4mm, WidthMag=0mm, Offset=0mm, Bridge=0mm, Rib=0mm, LenRegion=0mm, InfoCore=100)
  Tool_1 = Tool.copy()
  Band.subtract(Tool_1)
  Tool_2 = Tool.copy()
  InnerRegion.subtract(Tool_2)
  Tool_3 = Tool.copy()
  Shaft.subtract(Tool_3)
  Tool_4 = Tool.copy()
  Stator.subtract(Tool_4)
  Tool_5 = Tool.copy()
  Coil_0.subtract(Tool_5)
  Tool_6 = Tool.copy()
  Coil_1.subtract(Tool_6)
  Tool_7 = Tool.copy()
  Coil_2.subtract(Tool_7)
  Tool_8 = Tool.copy()
  Coil_3.subtract(Tool_8)
  Tool_9 = Tool.copy()
  Coil_4.subtract(Tool_9)
  Tool_10 = Tool.copy()
  Coil_5.subtract(Tool_10)
  Tool_11 = Tool.copy()
  Coil_6.subtract(Tool_11)
  Tool_12 = Tool.copy()
  Coil_7.subtract(Tool_12)
  Tool_13 = Tool.copy()
  Coil_8.subtract(Tool_13)
  Tool_14 = Tool.copy()
  Coil_9.subtract(Tool_14)
  Tool_15 = Tool.copy()
  Coil_10.subtract(Tool_15)
  Tool_16 = Tool.copy()
  Coil_11.subtract(Tool_16)
  Tool_17 = Tool.copy()
  Coil_12.subtract(Tool_17)
  Tool_18 = Tool.copy()
  Coil_13.subtract(Tool_18)
  Tool_19 = Tool.copy()
  Coil_14.subtract(Tool_19)
  Tool_20 = Tool.copy()
  Coil_15.subtract(Tool_20)
  Tool_21 = Tool.copy()
  Coil_16.subtract(Tool_21)
  Tool_22 = Tool.copy()
  Coil_17.subtract(Tool_22)
  Tool_23 = Tool.copy()
  Coil_18.subtract(Tool_23)
  Tool_24 = Tool.copy()
  Coil_19.subtract(Tool_24)
  Tool_25 = Tool.copy()
  Coil_20.subtract(Tool_25)
  Tool_26 = Tool.copy()
  Coil_21.subtract(Tool_26)
  Tool_27 = Tool.copy()
  Coil_22.subtract(Tool_27)
  Tool_28 = Tool.copy()
  Coil_23.subtract(Tool_28)
  Tool_29 = Tool.copy()
  Rotor.subtract(Tool_29)
  Tool_30 = Tool.copy()
  Mag_0.subtract(Tool_30)
  Tool_31 = Tool.copy()
  Mag_1.subtract(Tool_31)
  Tool_32 = Tool.copy()
  Mag_2.subtract(Tool_32)
  Mag_3.subtract(Tool)
  Polyline1 [vacuum, non-model] = polyline(z=0mm, xy in mm: (-60.007965, 2.8030106) (-58.688716, 12.823704) (-33.263076, 7.7328583) (-34.131075, 1.13975) (-60.007965, 2.8030106), closed, covered)
motion:
  MotionSetup1: Band Move_Type=Rotate Coordinate_System=Global Axis=Z Is_Positive=true InitPos=15deg Angular_Velocity=1500rpm Objects=Band
  Moving1: Moving Objects=[Shaft, Rotor, Mag_0..Mag_3, InnerRegion]
boundaries and excitations:
  VectorPotential1: Vector Potential Edges=OuterRegion.edge(at (0, 80, 0)) Value=0
  PhARe_0: Coil Objects=Coil_19 Conductor_number=64 Winding=PhaseA PolarityType=Negative
  PhA_0: Coil Objects=Coil_0 Conductor_number=64 Winding=PhaseA PolarityType=Positive
  PhA_1: Coil Objects=Coil_1 Conductor_number=64 Winding=PhaseA PolarityType=Positive
  PhARe_1: Coil Objects=Coil_6 Conductor_number=64 Winding=PhaseA PolarityType=Negative
  PhBRe_2: Coil Objects=Coil_23 Conductor_number=64 Winding=PhaseB PolarityType=Negative
  PhB_2: Coil Objects=Coil_4 Conductor_number=64 Winding=PhaseB PolarityType=Positive
  PhB_3: Coil Objects=Coil_5 Conductor_number=64 Winding=PhaseB PolarityType=Positive
  PhBRe_3: Coil Objects=Coil_10 Conductor_number=64 Winding=PhaseB PolarityType=Negative
  PhCRe_4: Coil Objects=Coil_3 Conductor_number=64 Winding=PhaseC PolarityType=Negative
  PhC_4: Coil Objects=Coil_8 Conductor_number=64 Winding=PhaseC PolarityType=Positive
  PhC_5: Coil Objects=Coil_9 Conductor_number=64 Winding=PhaseC PolarityType=Positive
  PhCRe_5: Coil Objects=Coil_14 Conductor_number=64 Winding=PhaseC PolarityType=Negative
  PhARe_6: Coil Objects=Coil_7 Conductor_number=64 Winding=PhaseA PolarityType=Negative
  PhA_6: Coil Objects=Coil_12 Conductor_number=64 Winding=PhaseA PolarityType=Positive
  PhA_7: Coil Objects=Coil_13 Conductor_number=64 Winding=PhaseA PolarityType=Positive
  PhARe_7: Coil Objects=Coil_18 Conductor_number=64 Winding=PhaseA PolarityType=Negative
  PhBRe_8: Coil Objects=Coil_11 Conductor_number=64 Winding=PhaseB PolarityType=Negative
  PhB_8: Coil Objects=Coil_16 Conductor_number=64 Winding=PhaseB PolarityType=Positive
  PhB_9: Coil Objects=Coil_17 Conductor_number=64 Winding=PhaseB PolarityType=Positive
  PhBRe_9: Coil Objects=Coil_22 Conductor_number=64 Winding=PhaseB PolarityType=Negative
  PhCRe_10: Coil Objects=Coil_15 Conductor_number=64 Winding=PhaseC PolarityType=Negative
  PhC_10: Coil Objects=Coil_20 Conductor_number=64 Winding=PhaseC PolarityType=Positive
  PhC_11: Coil Objects=Coil_21 Conductor_number=64 Winding=PhaseC PolarityType=Positive
  PhCRe_11: Coil Objects=Coil_2 Conductor_number=64 Winding=PhaseC PolarityType=Negative
  PhaseA: Winding Group Type=Voltage IsSolid=false Current=0A Resistance=0.821557ohm Inductance=0.000569985H Voltage="179.605 * sin(2*pi*50*time+0.0162481*pi/180)" ParallelBranchesNum=2
  PhaseB: Winding Group Type=Voltage IsSolid=false Current=0A Resistance=0.821557ohm Inductance=0.000569985H Voltage="179.605 * sin(2*pi*50*time+0.0162481*pi/180-2*pi/3)" ParallelBranchesNum=2
  PhaseC: Winding Group Type=Voltage IsSolid=false Current=0A Resistance=0.821557ohm Inductance=0.000569985H Voltage="179.605 * sin(2*pi*50*time+0.0162481*pi/180-4*pi/3)" ParallelBranchesNum=2
mesh:
  SurfApprox_Mag: SurfApproxBased Objects=[Mag_0..Mag_3] CurvedSurfaceApproxChoice=ManualSettings SurfDev=0.05mm NormalDev=15deg
  SurfApprox_Main: SurfApproxBased Objects=[Stator, Rotor, Band, OuterRegion, InnerRegion, Shaft] CurvedSurfaceApproxChoice=ManualSettings SurfDev=0.08mm NormalDev=15deg
  initial mesh: MeshMethod=AnsoftTAU
setups:
  Setup1: Transient NonlinearSolverResidual=0.0001 SmoothBHCurve StopTime=0.2s TimeStep=0.0002s InitialTimeStep=0.002s MinTimeStep=0.001s MaxTimeStep=0.003s TimeStepErrTolerance=0.0001
reports:
  Torque: Moving1.Torque vs Time on Setup1 : Transient
  Currents: Current(PhaseA), Current(PhaseB), Current(PhaseC) vs Time on Setup1 : Transient
  Induced Voltages: InducedVoltage(PhaseA), InducedVoltage(PhaseB), InducedVoltage(PhaseC) vs Time on Setup1 : Transient
  Flux Linkages: FluxLinkage(PhaseA), FluxLinkage(PhaseB), FluxLinkage(PhaseC) vs Time on Setup1 : Transient
  Voltages: InputVoltage(PhaseA), InputVoltage(PhaseB), InputVoltage(PhaseC) vs Time on Setup1 : Transient
  Powers: InputVoltage(PhaseA)*Current(PhaseA) + InputVoltage(PhaseB)*Current(PhaseB) + InputVoltage(PhaseC)*Current(PhaseC), Moving1.Speed*Moving1.Torque vs Time on Setup1 : Transient

design field (Maxwell 2D, Magnetostatic, XY geometry, model units mm)
variables:
  fractions = 1
geometry:
  Shaft [vacuum] = user_primitive(RMxprt/Band, DiaGap=101mm, DiaYoke=20mm, Length=0mm, SegAngle=0deg, Fractions=1, HalfAxial=0, InfoCore=100)
  OuterRegion [vacuum] = user_primitive(RMxprt/Band, DiaGap=101mm, DiaYoke=200mm, Length=0mm, SegAngle=0deg, Fractions=fractions, HalfAxial=0, InfoCore=100)
  Tool = user_primitive(RMxprt/Band, DiaGap=101mm, DiaYoke=160mm, Length=0mm, SegAngle=0deg, Fractions=fractions, HalfAxial=0, InfoCore=1)
  Rotor [M19-24G_2DSF0.950] = user_primitive(RMxprt/PMCore, DiaGap=100mm, DiaYoke=20mm, Length=0mm, Poles=4, PoleType=1, Embrace=0.8, ThickMag=4mm, WidthMag=0mm, Offset=0mm, Bridge=0mm, Rib=0mm, LenRegion=0mm, InfoCore=0)
  Mag_0 [NdFe42_2DSF1.000_N] = user_primitive(RMxprt/PMCore, DiaGap=100mm, DiaYoke=34mm, Length=0mm, Poles=4, PoleType=1, Embrace=0.8, ThickMag=4mm, WidthMag=0mm, Offset=0mm, Bridge=0mm, Rib=0mm, LenRegion=0mm, InfoCore=2)
  Mag_1 [NdFe42_2DSF1.000_S], Mag_2 [NdFe42_2DSF1.000_N], Mag_3 [NdFe42_2DSF1.000_S] = Mag_0.duplicate_around_axis(axis=Z, angle=90deg, total=4)
  InnerRegion [vacuum] = user_primitive(RMxprt/PMCore, DiaGap=100mm, DiaYoke=34mm, Length=0mm, Poles=4, PoleType=1, Embrace=0.8, ThickMag=4mm, WidthMag=0mm, Offset=0mm, Bridge=0mm, Rib=0mm, LenRegion=0mm, InfoCore=100)
  Tool_2 = Tool.copy()
  InnerRegion.subtract(Tool_2)
  Tool_3 = Tool.copy()
  Shaft.subtract(Tool_3)
  Tool_29 = Tool.copy()
  Rotor.subtract(Tool_29)
  Tool_30 = Tool.copy()
  Mag_0.subtract(Tool_30)
  Tool_31 = Tool.copy()
  Mag_1.subtract(Tool_31)
  Tool_32 = Tool.copy()
  Mag_2.subtract(Tool_32)
  Mag_3.subtract(Tool)
  Circle1 = circle(normal=Z, centre=(0mm, 0mm, 0mm), radius=51mm)
  stator_1 [M19-24G_2DSF0.950] = circle(normal=Z, centre=(0mm, 0mm, 0mm), radius=100mm)
  stator_1.subtract(Circle1)
  Polyline1 = polyline(z=0mm, xy in mm: (-50.5, 0) (3.0922332e-15, 50.5) (50.5, 0), AngularArc from point 0 over 3 centre=(0mm, 0mm, 0mm) angle=-180deg plane=XY)
boundaries and excitations:
  VectorPotential1: Vector Potential Edges=OuterRegion.edge(at (0, 100, 0)) Value=0
mesh:
  SurfApprox_Mag: SurfApproxBased Objects=[Mag_0..Mag_3] CurvedSurfaceApproxChoice=ManualSettings SurfDev=0.05mm NormalDev=15deg
  SurfApprox_Main: SurfApproxBased Objects=[Rotor, OuterRegion, InnerRegion, Shaft] CurvedSurfaceApproxChoice=ManualSettings SurfDev=0.08mm NormalDev=15deg
  initial mesh: MeshMethod=AnsoftTAU
setups:
  Setup1: Magnetostatic MaximumPasses=10 MinimumPasses=3 MinimumConvergedPasses=2 PercentRefinement=30 PercentError=1 NonLinearResidual=0.0001 SmoothBHCurve
field calculator expressions:
  BN1 = 2D_Normal | Fundamental_Quantity(22) | Dot
field plots:
  Mag_B1: B on Setup1 : LastAdaptive
reports:
  Air gap flux density: BN1 vs Distance on Setup1 : LastAdaptive; markers m2 at 121.84353mm

design pmsg-1 (RMxprt, Adjust-Speed Synchronous Machine, model units mm)
options: UDDEnabled UDD("Fractions 1")
machine:
  Machine: FrictionLoss=0W WindLoss=0W ReferenceSpeed=1500rpm NumberOfPoles=4 RotorPosition=true ControlType=3 CircuitType=L3
  Stator: SkewWidth=0 NumberOfSlots=24 LaminationSectors=0 PressBoardThickness=0mm OuterDiameter=160mm InnerDiameter=68.3mm Length=100mm StackingFactor=0.95 SteelType=M19-24G SlotType=3
  Rotor: OuterDiameter=66.3mm InnerDiameter=26mm Length=100mm SteelType=M19-24G PoleType=1 StackingFactor=0.95
  Shaft:
  Stator Slot: Hs0=0.0001mm Hs1=0.0001mm Hs2=24.72mm Bs0=3mm Bs1=5mm Bs2=11mm Rs=0mm ParallelTooth ToothWidth=5mm
  Stator Winding: WindingType=Whole-Coiled WindingLayers=1 ParallelBranches=1 ConductorsPerSlot=120 CoilPitch=5 EndAdjustment=0mm BaseInnerRadius=0mm TipInnerDiameter=0mm EndClearance=0mm CoilWrap=0mm SlotLiner=0.3mm WedgeThickness=0mm LayerInsulation=0mm BottomInsulation=0mm LimitedFillFactor=0.75 WdgNumberofPriodicMultipler=1 NumberOfStrands=1 WireWrap=0mm InterturnInsulation=0mm WireDiameter=0.8118mm WireWidth=0mm WireThickness=0mm Gauge=20
  Rotor Pole: Embrace=0.8 Offset=0mm ShaftDiameter=0mm Bridge=0mm Rib=0mm MagnetThickness=4mm MagnetWidth=0mm MagnetType=NdFe42
setups:
  Setup1: ASSM Motor RatedOutputPower=3.4kW RatedVoltage=923V RatedSpeed=1500rpm OperatingTemperature=75cel LoadType=ConstPower RatedPowerFactor=1

design Maxwell2DDesign1 (Maxwell 2D, Transient, XY geometry, model units mm)
options: ModelDepth=100mm Multiplier=fractions
variables:
  fractions = 1
  num_cond = 200
  fel = 50Hz
geometry:
  Band [vacuum] = user_primitive(RMxprt/Band, DiaGap=67.3mm, DiaYoke=26mm, Length=0mm, SegAngle=0deg, Fractions=1, HalfAxial=0, InfoCore=0)
  Shaft [vacuum] = user_primitive(RMxprt/Band, DiaGap=67.3mm, DiaYoke=26mm, Length=0mm, SegAngle=0deg, Fractions=1, HalfAxial=0, InfoCore=100)
  OuterRegion [vacuum] = user_primitive(RMxprt/Band, DiaGap=67.3mm, DiaYoke=160mm, Length=0mm, SegAngle=0deg, Fractions=fractions, HalfAxial=0, InfoCore=100)
  Tool = user_primitive(RMxprt/Band, DiaGap=67.3mm, DiaYoke=160mm, Length=0mm, SegAngle=0deg, Fractions=fractions, HalfAxial=0, InfoCore=1)
  Stator [M19-24G_2DSF0.951] = user_primitive(RMxprt/SlotCore, DiaGap=68.3mm, DiaYoke=160mm, Length=0mm, Skew=0deg, Slots=24, SlotType=3, Hs0=0.0001mm, Hs01=0mm, Hs1=0.0001mm, Hs2=24.72mm, Bs0=3mm, Bs1=3.9400952mm, Bs2=10.448995mm, Rs=0mm, FilletType=0, HalfSlot=0, SegAngle=15deg, LenRegion=0mm, InfoCore=0)
  Coil_0 [copper] = user_primitive(RMxprt/LapCoil, DiaGap=68.3mm, DiaYoke=160mm, Length=0mm, Skew=0deg, Slots=24, SlotType=3, Hs0=0.0001mm, Hs1=0.0001mm, Hs2=24.72mm, Bs0=3mm, Bs1=3.9400952mm, Bs2=10.448995mm, Rs=0mm, FilletType=0, Layers=1, CoilPitch=5, EndExt=0mm, SpanExt=0mm, BendAngle=0deg, SegAngle=10deg, LenRegion=0mm, InfoCoil=2)
  Coil_1..Coil_23 [copper] = Coil_0.duplicate_around_axis(axis=Z, angle=15deg, total=24)
  Rotor [M19-24G_2DSF0.951] = user_primitive(RMxprt/PMCore, DiaGap=66.3mm, DiaYoke=26mm, Length=0mm, Poles=4, PoleType=1, Embrace=0.8, ThickMag=4mm, WidthMag=0mm, Offset=0mm, Bridge=0mm, Rib=0mm, LenRegion=0mm, InfoCore=0)
  Mag_0 [NdFe42_2DSF1.000_N] = user_primitive(RMxprt/PMCore, DiaGap=66.3mm, DiaYoke=26mm, Length=0mm, Poles=4, PoleType=1, Embrace=0.8, ThickMag=4mm, WidthMag=0mm, Offset=0mm, Bridge=0mm, Rib=0mm, LenRegion=0mm, InfoCore=2)
  Mag_1 [NdFe42_2DSF1.000_S], Mag_2 [NdFe42_2DSF1.000_N], Mag_3 [NdFe42_2DSF1.000_S] = Mag_0.duplicate_around_axis(axis=Z, angle=90deg, total=4)
  InnerRegion [vacuum] = user_primitive(RMxprt/PMCore, DiaGap=66.3mm, DiaYoke=26mm, Length=0mm, Poles=4, PoleType=1, Embrace=0.8, ThickMag=4mm, WidthMag=0mm, Offset=0mm, Bridge=0mm, Rib=0mm, LenRegion=0mm, InfoCore=100)
  Tool_1 = Tool.copy()
  Band.subtract(Tool_1)
  Tool_2 = Tool.copy()
  InnerRegion.subtract(Tool_2)
  Tool_3 = Tool.copy()
  Shaft.subtract(Tool_3)
  Tool_4 = Tool.copy()
  Stator.subtract(Tool_4)
  Tool_5 = Tool.copy()
  Coil_0.subtract(Tool_5)
  Tool_6 = Tool.copy()
  Coil_1.subtract(Tool_6)
  Tool_7 = Tool.copy()
  Coil_2.subtract(Tool_7)
  Tool_8 = Tool.copy()
  Coil_3.subtract(Tool_8)
  Tool_9 = Tool.copy()
  Coil_4.subtract(Tool_9)
  Tool_10 = Tool.copy()
  Coil_5.subtract(Tool_10)
  Tool_11 = Tool.copy()
  Coil_6.subtract(Tool_11)
  Tool_12 = Tool.copy()
  Coil_7.subtract(Tool_12)
  Tool_13 = Tool.copy()
  Coil_8.subtract(Tool_13)
  Tool_14 = Tool.copy()
  Coil_9.subtract(Tool_14)
  Tool_15 = Tool.copy()
  Coil_10.subtract(Tool_15)
  Tool_16 = Tool.copy()
  Coil_11.subtract(Tool_16)
  Tool_17 = Tool.copy()
  Coil_12.subtract(Tool_17)
  Tool_18 = Tool.copy()
  Coil_13.subtract(Tool_18)
  Tool_19 = Tool.copy()
  Coil_14.subtract(Tool_19)
  Tool_20 = Tool.copy()
  Coil_15.subtract(Tool_20)
  Tool_21 = Tool.copy()
  Coil_16.subtract(Tool_21)
  Tool_22 = Tool.copy()
  Coil_17.subtract(Tool_22)
  Tool_23 = Tool.copy()
  Coil_18.subtract(Tool_23)
  Tool_24 = Tool.copy()
  Coil_19.subtract(Tool_24)
  Tool_25 = Tool.copy()
  Coil_20.subtract(Tool_25)
  Tool_26 = Tool.copy()
  Coil_21.subtract(Tool_26)
  Tool_27 = Tool.copy()
  Coil_22.subtract(Tool_27)
  Tool_28 = Tool.copy()
  Coil_23.subtract(Tool_28)
  Tool_29 = Tool.copy()
  Rotor.subtract(Tool_29)
  Tool_30 = Tool.copy()
  Mag_0.subtract(Tool_30)
  Tool_31 = Tool.copy()
  Mag_1.subtract(Tool_31)
  Tool_32 = Tool.copy()
  Mag_2.subtract(Tool_32)
  Mag_3.subtract(Tool)
motion:
  MotionSetup1: Band Move_Type=Rotate Coordinate_System=Global Axis=Z Is_Positive=true InitPos=360deg/24 Angular_Velocity=1500rpm Objects=Band
  Moving1: Moving Objects=[Shaft, Rotor, Mag_0..Mag_3, InnerRegion]
boundaries and excitations:
  VectorPotential1: Vector Potential Edges=OuterRegion.edge(at (0, 80, 0)) Value=0
  PhARe_0: Coil Objects=Coil_19 Conductor_number=num_cond Winding=PhaseA PolarityType=Negative
  PhA_0: Coil Objects=Coil_0 Conductor_number=num_cond Winding=PhaseA PolarityType=Positive
  PhA_1: Coil Objects=Coil_1 Conductor_number=num_cond Winding=PhaseA PolarityType=Positive
  PhARe_1: Coil Objects=Coil_6 Conductor_number=num_cond Winding=PhaseA PolarityType=Negative
  PhBRe_2: Coil Objects=Coil_23 Conductor_number=num_cond Winding=PhaseB PolarityType=Negative
  PhB_2: Coil Objects=Coil_4 Conductor_number=num_cond Winding=PhaseB PolarityType=Positive
  PhB_3: Coil Objects=Coil_5 Conductor_number=num_cond Winding=PhaseB PolarityType=Positive
  PhBRe_3: Coil Objects=Coil_10 Conductor_number=num_cond Winding=PhaseB PolarityType=Negative
  PhCRe_4: Coil Objects=Coil_3 Conductor_number=num_cond Winding=PhaseC PolarityType=Negative
  PhC_4: Coil Objects=Coil_8 Conductor_number=num_cond Winding=PhaseC PolarityType=Positive
  PhC_5: Coil Objects=Coil_9 Conductor_number=num_cond Winding=PhaseC PolarityType=Positive
  PhCRe_5: Coil Objects=Coil_14 Conductor_number=num_cond Winding=PhaseC PolarityType=Negative
  PhARe_6: Coil Objects=Coil_7 Conductor_number=num_cond Winding=PhaseA PolarityType=Negative
  PhA_6: Coil Objects=Coil_12 Conductor_number=num_cond Winding=PhaseA PolarityType=Positive
  PhA_7: Coil Objects=Coil_13 Conductor_number=num_cond Winding=PhaseA PolarityType=Positive
  PhARe_7: Coil Objects=Coil_18 Conductor_number=num_cond Winding=PhaseA PolarityType=Negative
  PhBRe_8: Coil Objects=Coil_11 Conductor_number=num_cond Winding=PhaseB PolarityType=Negative
  PhB_8: Coil Objects=Coil_16 Conductor_number=num_cond Winding=PhaseB PolarityType=Positive
  PhB_9: Coil Objects=Coil_17 Conductor_number=num_cond Winding=PhaseB PolarityType=Positive
  PhBRe_9: Coil Objects=Coil_22 Conductor_number=num_cond Winding=PhaseB PolarityType=Negative
  PhCRe_10: Coil Objects=Coil_15 Conductor_number=num_cond Winding=PhaseC PolarityType=Negative
  PhC_10: Coil Objects=Coil_20 Conductor_number=num_cond Winding=PhaseC PolarityType=Positive
  PhC_11: Coil Objects=Coil_21 Conductor_number=num_cond Winding=PhaseC PolarityType=Positive
  PhCRe_11: Coil Objects=Coil_2 Conductor_number=num_cond Winding=PhaseC PolarityType=Negative
  PhaseA: Winding Group Type=Current IsSolid=false Current=2.5*sqrt(2)*sin(2*pi*fel*time) ParallelBranchesNum=1
  PhaseB: Winding Group Type=Current IsSolid=false Current=2.5*sqrt(2)*sin(2*pi*fel*time-2*pi/3) ParallelBranchesNum=1
  PhaseC: Winding Group Type=Current IsSolid=false Current=2.5*sqrt(2)*sin(2*pi*fel*time+2*pi/3) ParallelBranchesNum=1
mesh:
  SurfApprox_Mag: SurfApproxBased Objects=[Mag_0..Mag_3] CurvedSurfaceApproxChoice=ManualSettings SurfDev=0.03315mm NormalDev=15deg
  SurfApprox_Main: SurfApproxBased Objects=[Stator, Rotor, Band, OuterRegion, InnerRegion, Shaft] CurvedSurfaceApproxChoice=ManualSettings SurfDev=0.08mm NormalDev=15deg
  initial mesh: MeshMethod=AnsoftTAU
setups:
  Setup1: Transient NonlinearSolverResidual=0.0001 SmoothBHCurve StopTime=0.2s TimeStep=0.0002s SweepSetupType=LinearStep StartValue=0ns StopValue=10000000ns StepSize=5000000ns InitialTimeStep=0.002s MinTimeStep=0.001s MaxTimeStep=0.003s TimeStepErrTolerance=0.0001
field plots:
  Mag_B1: B over Rotor, Stator on Setup1 : Transient at Time=-1
reports:
  Torque: Moving1.Torque vs Time on Setup1 : Transient
  Currents: InputCurrent(PhaseA), InputCurrent(PhaseB), InputCurrent(PhaseC) vs Time on Setup1 : Transient
  Induced Voltages: InducedVoltage(PhaseA), InducedVoltage(PhaseB), InducedVoltage(PhaseC) vs Time on Setup1 : Transient
  Flux Linkages: FluxLinkage(PhaseA), FluxLinkage(PhaseB), FluxLinkage(PhaseC) vs Time on Setup1 : Transient
  Voltages: InputVoltage(PhaseA), InputVoltage(PhaseB), InputVoltage(PhaseC) vs Time on Setup1 : Transient
  Powers: InputVoltage(PhaseA)*Current(PhaseA) + InputVoltage(PhaseB)*Current(PhaseB) + InputVoltage(PhaseC)*Current(PhaseC), Moving1.Speed*Moving1.Torque vs Time on Setup1 : Transient

design ferrite (Maxwell 2D, Transient, XY geometry, model units mm)
options: ModelDepth=100mm Multiplier=fractions
variables:
  fractions = 1
  num_cond = 200
  fel = 50Hz
geometry:
  Band [vacuum] = user_primitive(RMxprt/Band, DiaGap=67.3mm, DiaYoke=26mm, Length=0mm, SegAngle=0deg, Fractions=1, HalfAxial=0, InfoCore=0)
  Shaft [vacuum] = user_primitive(RMxprt/Band, DiaGap=67.3mm, DiaYoke=26mm, Length=0mm, SegAngle=0deg, Fractions=1, HalfAxial=0, InfoCore=100)
  OuterRegion [vacuum] = user_primitive(RMxprt/Band, DiaGap=67.3mm, DiaYoke=160mm, Length=0mm, SegAngle=0deg, Fractions=fractions, HalfAxial=0, InfoCore=100)
  Tool = user_primitive(RMxprt/Band, DiaGap=67.3mm, DiaYoke=160mm, Length=0mm, SegAngle=0deg, Fractions=fractions, HalfAxial=0, InfoCore=1)
  Stator [M19-24G_2DSF0.951] = user_primitive(RMxprt/SlotCore, DiaGap=68.3mm, DiaYoke=160mm, Length=0mm, Skew=0deg, Slots=24, SlotType=3, Hs0=0.0001mm, Hs01=0mm, Hs1=0.0001mm, Hs2=24.72mm, Bs0=3mm, Bs1=3.9400952mm, Bs2=10.448995mm, Rs=0mm, FilletType=0, HalfSlot=0, SegAngle=15deg, LenRegion=0mm, InfoCore=0)
  Coil_0 [copper] = user_primitive(RMxprt/LapCoil, DiaGap=68.3mm, DiaYoke=160mm, Length=0mm, Skew=0deg, Slots=24, SlotType=3, Hs0=0.0001mm, Hs1=0.0001mm, Hs2=24.72mm, Bs0=3mm, Bs1=3.9400952mm, Bs2=10.448995mm, Rs=0mm, FilletType=0, Layers=1, CoilPitch=5, EndExt=0mm, SpanExt=0mm, BendAngle=0deg, SegAngle=10deg, LenRegion=0mm, InfoCoil=2)
  Coil_1..Coil_23 [copper] = Coil_0.duplicate_around_axis(axis=Z, angle=15deg, total=24)
  Rotor [M19-24G_2DSF0.951] = user_primitive(RMxprt/PMCore, DiaGap=66.3mm, DiaYoke=26mm, Length=0mm, Poles=4, PoleType=1, Embrace=0.8, ThickMag=4mm, WidthMag=0mm, Offset=0mm, Bridge=0mm, Rib=0mm, LenRegion=0mm, InfoCore=0)
  Mag_0 [NdFe42_2DSF1.000_N] = user_primitive(RMxprt/PMCore, DiaGap=66.3mm, DiaYoke=26mm, Length=0mm, Poles=4, PoleType=1, Embrace=0.8, ThickMag=4mm, WidthMag=0mm, Offset=0mm, Bridge=0mm, Rib=0mm, LenRegion=0mm, InfoCore=2)
  Mag_1 [NdFe42_2DSF1.000_S], Mag_2 [NdFe42_2DSF1.000_N], Mag_3 [NdFe42_2DSF1.000_S] = Mag_0.duplicate_around_axis(axis=Z, angle=90deg, total=4)
  InnerRegion [vacuum] = user_primitive(RMxprt/PMCore, DiaGap=66.3mm, DiaYoke=26mm, Length=0mm, Poles=4, PoleType=1, Embrace=0.8, ThickMag=4mm, WidthMag=0mm, Offset=0mm, Bridge=0mm, Rib=0mm, LenRegion=0mm, InfoCore=100)
  Tool_1 = Tool.copy()
  Band.subtract(Tool_1)
  Tool_2 = Tool.copy()
  InnerRegion.subtract(Tool_2)
  Tool_3 = Tool.copy()
  Shaft.subtract(Tool_3)
  Tool_4 = Tool.copy()
  Stator.subtract(Tool_4)
  Tool_5 = Tool.copy()
  Coil_0.subtract(Tool_5)
  Tool_6 = Tool.copy()
  Coil_1.subtract(Tool_6)
  Tool_7 = Tool.copy()
  Coil_2.subtract(Tool_7)
  Tool_8 = Tool.copy()
  Coil_3.subtract(Tool_8)
  Tool_9 = Tool.copy()
  Coil_4.subtract(Tool_9)
  Tool_10 = Tool.copy()
  Coil_5.subtract(Tool_10)
  Tool_11 = Tool.copy()
  Coil_6.subtract(Tool_11)
  Tool_12 = Tool.copy()
  Coil_7.subtract(Tool_12)
  Tool_13 = Tool.copy()
  Coil_8.subtract(Tool_13)
  Tool_14 = Tool.copy()
  Coil_9.subtract(Tool_14)
  Tool_15 = Tool.copy()
  Coil_10.subtract(Tool_15)
  Tool_16 = Tool.copy()
  Coil_11.subtract(Tool_16)
  Tool_17 = Tool.copy()
  Coil_12.subtract(Tool_17)
  Tool_18 = Tool.copy()
  Coil_13.subtract(Tool_18)
  Tool_19 = Tool.copy()
  Coil_14.subtract(Tool_19)
  Tool_20 = Tool.copy()
  Coil_15.subtract(Tool_20)
  Tool_21 = Tool.copy()
  Coil_16.subtract(Tool_21)
  Tool_22 = Tool.copy()
  Coil_17.subtract(Tool_22)
  Tool_23 = Tool.copy()
  Coil_18.subtract(Tool_23)
  Tool_24 = Tool.copy()
  Coil_19.subtract(Tool_24)
  Tool_25 = Tool.copy()
  Coil_20.subtract(Tool_25)
  Tool_26 = Tool.copy()
  Coil_21.subtract(Tool_26)
  Tool_27 = Tool.copy()
  Coil_22.subtract(Tool_27)
  Tool_28 = Tool.copy()
  Coil_23.subtract(Tool_28)
  Tool_29 = Tool.copy()
  Rotor.subtract(Tool_29)
  Tool_30 = Tool.copy()
  Mag_0.subtract(Tool_30)
  Tool_31 = Tool.copy()
  Mag_1.subtract(Tool_31)
  Tool_32 = Tool.copy()
  Mag_2.subtract(Tool_32)
  Mag_3.subtract(Tool)
motion:
  MotionSetup1: Band Move_Type=Rotate Coordinate_System=Global Axis=Z Is_Positive=true InitPos=360deg/24 Angular_Velocity=1500rpm Objects=Band
  Moving1: Moving Objects=[Shaft, Rotor, Mag_0..Mag_3, InnerRegion]
boundaries and excitations:
  VectorPotential1: Vector Potential Edges=OuterRegion.edge(at (0, 80, 0)) Value=0
  PhARe_0: Coil Objects=Coil_19 Conductor_number=num_cond Winding=PhaseA PolarityType=Negative
  PhA_0: Coil Objects=Coil_0 Conductor_number=num_cond Winding=PhaseA PolarityType=Positive
  PhA_1: Coil Objects=Coil_1 Conductor_number=num_cond Winding=PhaseA PolarityType=Positive
  PhARe_1: Coil Objects=Coil_6 Conductor_number=num_cond Winding=PhaseA PolarityType=Negative
  PhBRe_2: Coil Objects=Coil_23 Conductor_number=num_cond Winding=PhaseB PolarityType=Negative
  PhB_2: Coil Objects=Coil_4 Conductor_number=num_cond Winding=PhaseB PolarityType=Positive
  PhB_3: Coil Objects=Coil_5 Conductor_number=num_cond Winding=PhaseB PolarityType=Positive
  PhBRe_3: Coil Objects=Coil_10 Conductor_number=num_cond Winding=PhaseB PolarityType=Negative
  PhCRe_4: Coil Objects=Coil_3 Conductor_number=num_cond Winding=PhaseC PolarityType=Negative
  PhC_4: Coil Objects=Coil_8 Conductor_number=num_cond Winding=PhaseC PolarityType=Positive
  PhC_5: Coil Objects=Coil_9 Conductor_number=num_cond Winding=PhaseC PolarityType=Positive
  PhCRe_5: Coil Objects=Coil_14 Conductor_number=num_cond Winding=PhaseC PolarityType=Negative
  PhARe_6: Coil Objects=Coil_7 Conductor_number=num_cond Winding=PhaseA PolarityType=Negative
  PhA_6: Coil Objects=Coil_12 Conductor_number=num_cond Winding=PhaseA PolarityType=Positive
  PhA_7: Coil Objects=Coil_13 Conductor_number=num_cond Winding=PhaseA PolarityType=Positive
  PhARe_7: Coil Objects=Coil_18 Conductor_number=num_cond Winding=PhaseA PolarityType=Negative
  PhBRe_8: Coil Objects=Coil_11 Conductor_number=num_cond Winding=PhaseB PolarityType=Negative
  PhB_8: Coil Objects=Coil_16 Conductor_number=num_cond Winding=PhaseB PolarityType=Positive
  PhB_9: Coil Objects=Coil_17 Conductor_number=num_cond Winding=PhaseB PolarityType=Positive
  PhBRe_9: Coil Objects=Coil_22 Conductor_number=num_cond Winding=PhaseB PolarityType=Negative
  PhCRe_10: Coil Objects=Coil_15 Conductor_number=num_cond Winding=PhaseC PolarityType=Negative
  PhC_10: Coil Objects=Coil_20 Conductor_number=num_cond Winding=PhaseC PolarityType=Positive
  PhC_11: Coil Objects=Coil_21 Conductor_number=num_cond Winding=PhaseC PolarityType=Positive
  PhCRe_11: Coil Objects=Coil_2 Conductor_number=num_cond Winding=PhaseC PolarityType=Negative
  PhaseA: Winding Group Type=Current IsSolid=false Current=2.5*sqrt(2)*sin(2*pi*fel*time) ParallelBranchesNum=1
  PhaseB: Winding Group Type=Current IsSolid=false Current=2.5*sqrt(2)*sin(2*pi*fel*time-2*pi/3) ParallelBranchesNum=1
  PhaseC: Winding Group Type=Current IsSolid=false Current=2.5*sqrt(2)*sin(2*pi*fel*time+2*pi/3) ParallelBranchesNum=1
mesh:
  SurfApprox_Mag: SurfApproxBased Objects=[Mag_0..Mag_3] CurvedSurfaceApproxChoice=ManualSettings SurfDev=0.03315mm NormalDev=15deg
  SurfApprox_Main: SurfApproxBased Objects=[Stator, Rotor, Band, OuterRegion, InnerRegion, Shaft] CurvedSurfaceApproxChoice=ManualSettings SurfDev=0.08mm NormalDev=15deg
  initial mesh: MeshMethod=AnsoftTAU
setups:
  Setup1: Transient NonlinearSolverResidual=0.0001 SmoothBHCurve StopTime=0.2s TimeStep=0.0002s SweepSetupType=LinearStep StartValue=0ns StopValue=10000000ns StepSize=5000000ns InitialTimeStep=0.002s MinTimeStep=0.001s MaxTimeStep=0.003s TimeStepErrTolerance=0.0001
field plots:
  Mag_B1: B over Rotor, Stator on Setup1 : Transient at Time=-1
reports:
  Torque: Moving1.Torque vs Time on Setup1 : Transient
  Currents: InputCurrent(PhaseA), InputCurrent(PhaseB), InputCurrent(PhaseC) vs Time on Setup1 : Transient
  Induced Voltages: InducedVoltage(PhaseA), InducedVoltage(PhaseB), InducedVoltage(PhaseC) vs Time on Setup1 : Transient
  Flux Linkages: FluxLinkage(PhaseA), FluxLinkage(PhaseB), FluxLinkage(PhaseC) vs Time on Setup1 : Transient
  Voltages: InputVoltage(PhaseA), InputVoltage(PhaseB), InputVoltage(PhaseC) vs Time on Setup1 : Transient
  Powers: InputVoltage(PhaseA)*Current(PhaseA) + InputVoltage(PhaseB)*Current(PhaseB) + InputVoltage(PhaseC)*Current(PhaseC), Moving1.Speed*Moving1.Torque vs Time on Setup1 : Transient
